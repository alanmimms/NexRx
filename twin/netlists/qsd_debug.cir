* NexRx Digital Twin - QSD Debug Test
* Single QSD with LO at exactly RF frequency
* Shows RF input and all 4 sampling capacitor voltages
*
* Copyright 2026 NexRx Project - MIT License

.INCLUDE 'components.lib'
.INCLUDE 'qsd.lib'

*======================================================================
* TEST CIRCUIT - Single QSD at 14 MHz
*======================================================================

* RF Input - 14 MHz tone, 50mV peak (representing signal after pentafilar)
V_RF RF_SRC 0 SIN(0 0.05 14MEG)
R_RF_SRC RF_SRC RF_IN 50

*----------------------------------------------------------------------
* QSD0 LO at exactly 14 MHz (4 phases: 0, 90, 180, 270 degrees)
* Period = 71.43ns, each phase offset by 17.86ns
*----------------------------------------------------------------------

* Generate sine waves, then square them up
V_PH0_S PH0_S 0 SIN(1.65 1.65 14MEG 0)
V_PH1_S PH1_S 0 SIN(1.65 1.65 14MEG 17.857n)
V_PH2_S PH2_S 0 SIN(1.65 1.65 14MEG 35.714n)
V_PH3_S PH3_S 0 SIN(1.65 1.65 14MEG 53.571n)

* Convert to square waves (0V or 3.3V)
B_PH0 PH0 0 V='3.3 * (1 + tanh(100*(V(PH0_S) - 1.65))) / 2'
B_PH1 PH1 0 V='3.3 * (1 + tanh(100*(V(PH1_S) - 1.65))) / 2'
B_PH2 PH2 0 V='3.3 * (1 + tanh(100*(V(PH2_S) - 1.65))) / 2'
B_PH3 PH3 0 V='3.3 * (1 + tanh(100*(V(PH3_S) - 1.65))) / 2'

*----------------------------------------------------------------------
* QSD Instance
*----------------------------------------------------------------------
X_QSD RF_IN 0 I_OUT Q_OUT PH0 PH1 PH2 PH3 QSD_4PHASE

* Output loads (ADC input impedance)
R_LOAD_I I_OUT 0 10k
R_LOAD_Q Q_OUT 0 10k

*----------------------------------------------------------------------
* Analysis - 2us = ~28 RF cycles
* At 14 MHz, period = 71.4ns, need ~5ns timestep for 14 samples/cycle
*----------------------------------------------------------------------
.TRAN 0 2u 0 5n
.OPTIONS TIMEINT DELMAX=5n

*----------------------------------------------------------------------
* Print QSD internal signals:
*   RF_AC  - RF after coupling cap (input to switches)
*   SAMP0-3 - Four sampling capacitor voltages
*----------------------------------------------------------------------
.PRINT TRAN
+ V(X_QSD:RF_AC)
+ V(X_QSD:SAMP0) V(X_QSD:SAMP1) V(X_QSD:SAMP2) V(X_QSD:SAMP3)
+ V(PH0) V(I_OUT) V(Q_OUT)

.END
