* NexRx Digital Twin - Transformer Models
* Impedance matching transformers for RF signal path
*
* Reference: RX-ARCHITECTURE.md Section "Impedance Transformation"
*
* Signal path impedances:
*   Antenna 50Ω → 200Ω → Attenuator → 800Ω → Preselector → 3×50Ω → QSDs
*
* Copyright 2026 NexRx Project - MIT License

.INCLUDE 'components.lib'

*======================================================================
* 50 to 200 OHM TRANSFORMER (1:2 turns, 1:4 impedance)
* Autotransformer on FT50-43 ferrite toroid
* Primary inductance ~10uH for good low-frequency response
*======================================================================

.SUBCKT XFMR_50_200 IN_50 GND OUT_200
* Coupled inductor model
* Turns ratio 1:2, so L2 = 4*L1 for equal flux linkage
* L1 = 2.5uH (50 ohm section), L2_total = 10uH
L_LO IN_50 GND 2.5u
L_HI IN_50 OUT_200 7.5u
K_AUTO L_LO L_HI 0.995
* Small winding resistance
R_LOSS IN_50 1_INT 0.1
.ENDS XFMR_50_200

*======================================================================
* 200 to 800 OHM TRANSFORMER (1:2 turns, 1:4 impedance)
* Autotransformer on FT50-43 ferrite toroid
*======================================================================

.SUBCKT XFMR_200_800 IN_200 GND OUT_800
* Coupled inductor model
* Turns ratio 1:2 for 200:800 ohm transformation
L_LO IN_200 GND 10u
L_HI IN_200 OUT_800 30u
K_AUTO L_LO L_HI 0.995
* Small winding resistance
R_LOSS IN_200 1_INT 0.2
.ENDS XFMR_200_800

*======================================================================
* 800 OHM TO 3x50 OHM SPLITTER TRANSFORMER
* Trifilar wound for matched outputs to three QSDs
* Primary: 16 turns (800 ohm), Secondaries: 4 turns each (~50 ohm)
* Core: FT50-43 binocular
*======================================================================

.SUBCKT XFMR_800_3X50 IN_800 GND OUT_A OUT_B OUT_C
* Primary inductance ~40uH for good coupling
* Secondary inductance ~2.5uH each (turns ratio 4:1)
* Leakage inductance provides low output impedance (~2-4 ohms)

L_PRI IN_800 GND 40u

* Three matched secondaries - tightly coupled to primary
* Each secondary referenced to ground
L_SEC_A OUT_A GND 2.5u
L_SEC_B OUT_B GND 2.5u
L_SEC_C OUT_C GND 2.5u

* Coupling coefficients (high for trifilar)
K_PA L_PRI L_SEC_A 0.98
K_PB L_PRI L_SEC_B 0.98
K_PC L_PRI L_SEC_C 0.98

* Inter-secondary coupling (very high for trifilar wound)
K_AB L_SEC_A L_SEC_B 0.995
K_AC L_SEC_A L_SEC_C 0.995
K_BC L_SEC_B L_SEC_C 0.995

* Small leakage inductance + winding resistance models low Zout
R_LEAK_A OUT_A 1_A 2.0
R_LEAK_B OUT_B 1_B 2.0
R_LEAK_C OUT_C 1_C 2.0

.ENDS XFMR_800_3X50

*======================================================================
* TEST CIRCUIT - Full transformer chain with 14 MHz signal
*======================================================================

* Input source - 50 ohm matched
VIN IN_SRC 0 SIN(0 0.1 14MEG)
R_SRC IN_SRC IN_50 50

* 50 to 200 ohm transformer
X_T1 IN_50 0 NODE_200 XFMR_50_200

* Attenuator placeholder (0 dB for now - just wire)
R_ATTEN NODE_200 NODE_200B 0.1

* 200 to 800 ohm transformer
X_T2 NODE_200B 0 NODE_800 XFMR_200_800

* Preselector placeholder (just LC at 14 MHz)
* L = 180nH, C = 716pF for 14 MHz resonance
L_PRESEL NODE_800 NODE_800_LC 180n
C_PRESEL NODE_800_LC 0 716p
R_Q NODE_800 NODE_800_LC 10

* 800 to 3x50 ohm splitter
X_T3 NODE_800_LC 0 QSD_A QSD_B QSD_C XFMR_800_3X50

* 50 ohm loads representing QSD inputs
R_LOAD_A QSD_A 0 50
R_LOAD_B QSD_B 0 50
R_LOAD_C QSD_C 0 50

* Analysis
.TRAN 1n 1u

* Print outputs
.PRINT TRAN V(IN_50) V(NODE_200) V(NODE_800) V(QSD_A) V(QSD_B) V(QSD_C)

.END
