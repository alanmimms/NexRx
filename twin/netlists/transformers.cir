* NexRx Digital Twin - Transformer Models
* Impedance matching transformers for RF signal path
*
* Reference: RX-ARCHITECTURE.md Section "Impedance Transformation"
*
* Signal path impedances:
*   Antenna 50Ω → 200Ω → Attenuator → Preselector → 3×22Ω → QSDs
*
* Copyright 2026 NexRx Project - MIT License

.INCLUDE 'components.lib'

*======================================================================
* 50 TO 200 OHM AUTOTRANSFORMER
* Bifilar wound autotransformer on BN-43-202 binocular core
*
* Construction:
*   - Bifilar winding: 3-4 twists/inch, #30AWG
*   - 4 turns on BN-43-202 core
*   - Centertap feed from antenna (50 ohm)
*   - Full winding output to 200 ohm zone
*
* BN-43-202 AL ≈ 2200 nH/turn²
*   - 2-turn section (antenna to centertap): L = 2200 × 4 = 8.8 µH
*   - 4-turn total: L = 2200 × 16 = 35.2 µH
*
* Impedance ratio: (4/2)² = 4:1, so 50Ω → 200Ω
*======================================================================

.SUBCKT XFMR_50_200_AUTO IN_50 GND OUT_200
* Autotransformer model with centertap feed
* IN_50 connects to centertap (2 turns from ground)
* OUT_200 is full winding (4 turns from ground)

* Lower section: ground to centertap (2 turns)
L_LO GND IN_50 8.8u

* Upper section: centertap to output (2 more turns)
L_HI IN_50 OUT_200 8.8u

* Tight coupling between sections (bifilar wound)
K_AUTO L_LO L_HI 0.995

* Winding resistance (#30AWG, ~2 inches total)
R_LO GND GND_INT 0.05
R_HI OUT_200 OUT_INT 0.05

.ENDS XFMR_50_200_AUTO

*======================================================================
* IDEAL 50 TO 200 OHM TRANSFORMER
* For faster simulation / debugging
* Uses dependent sources to enforce exact 2:1 turns ratio
*======================================================================

.SUBCKT XFMR_50_200_IDEAL IN_50 GND OUT_200
* Voltage scaling: V_out = V_in × 2 (for 50→200 ohm)
E_OUT OUT_200 GND IN_50 GND 2.0

* Current scaling (for power balance)
* Not modeled here - ideal transformer
.ENDS XFMR_50_200_IDEAL

*======================================================================
* TEST CIRCUIT - Full transformer chain with 14 MHz signal
* Signal path: 50Ω antenna → 200Ω → Preselector → 3×22Ω → QSDs
*======================================================================

* Input source - 50 ohm matched antenna
VIN IN_SRC 0 SIN(0 0.1 14MEG)
R_SRC IN_SRC IN_50 50

* 50 to 200 ohm autotransformer
X_T1 IN_50 0 NODE_200 XFMR_50_200_AUTO

* DC blocking capacitor (100nF)
C_DCBLOCK NODE_200 NODE_200B 100n

* Attenuator placeholder (0 dB for now - just wire)
R_ATTEN NODE_200B NODE_200C 0.1

* Preselector placeholder (LC tank tuned to 14 MHz at 200 ohm)
* f = 1/(2*pi*sqrt(L*C)) -> L = 180nH, C = 716pF for 14 MHz
L_PRESEL NODE_200C NODE_LC 180n
C_PRESEL NODE_LC 0 716p
R_Q NODE_200C NODE_LC 10

* Include hexafilar transformer model
.INCLUDE 'hexafilar.lib'

* 200 to 3x22 ohm hexafilar transformer
X_T2 NODE_LC 0 QSD_A QSD_B QSD_C 0 XFMR_HEXAFILAR

* 22 ohm loads representing QSD input impedance
R_LOAD_A QSD_A 0 22
R_LOAD_B QSD_B 0 22
R_LOAD_C QSD_C 0 22

* Analysis
.TRAN 1n 1u

* Print outputs
.PRINT TRAN V(IN_50) V(NODE_200) V(NODE_LC) V(QSD_A) V(QSD_B) V(QSD_C)

.END
