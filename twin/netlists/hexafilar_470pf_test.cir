* NexRx Digital Twin - Hexafilar + QSD with 470pF caps
*
* Test transformer loading with smaller sampling caps
*
* Copyright 2026 NexRx Project - MIT License

.INCLUDE 'components.lib'
.INCLUDE 'qsd.lib'
.INCLUDE 'hexafilar.lib'

.PARAM F_RF=14.01MEG
.PARAM F_LO=14MEG
.PARAM T_LO='1/F_LO'
.PARAM T_PHASE='T_LO/4'

*======================================================================
* RF SOURCE - 100mV peak at 14.01 MHz, 200 ohm source
*======================================================================
V_RF RF_SRC 0 SIN(0 0.1 {F_RF})
R_RF_SRC RF_SRC PRI_P 200

*======================================================================
* Hexafilar with QSD using 470pF caps
*======================================================================
X_HEXA PRI_P 0 SEC_A SEC_B SEC_C 0 XFMR_HEXAFILAR

* QSD LO generation
V_PH0_S PH0_S 0 SIN(1.65 1.65 {F_LO} 0)
V_PH1_S PH1_S 0 SIN(1.65 1.65 {F_LO} {T_PHASE})
V_PH2_S PH2_S 0 SIN(1.65 1.65 {F_LO} {2*T_PHASE})
V_PH3_S PH3_S 0 SIN(1.65 1.65 {F_LO} {3*T_PHASE})

B_PH0 PH0 0 V='3.3 * (1 + tanh(100*(V(PH0_S) - 1.65))) / 2'
B_PH1 PH1 0 V='3.3 * (1 + tanh(100*(V(PH1_S) - 1.65))) / 2'
B_PH2 PH2 0 V='3.3 * (1 + tanh(100*(V(PH2_S) - 1.65))) / 2'
B_PH3 PH3 0 V='3.3 * (1 + tanh(100*(V(PH3_S) - 1.65))) / 2'

* QSD on SEC_A with 470pF caps (override default 33nF)
X_QSD SEC_A 0 I_OUT Q_OUT PH0 PH1 PH2 PH3 QSD_4PHASE CSAMP=470p

* Terminate unused secondaries
R_LOAD_B SEC_B 0 22
R_LOAD_C SEC_C 0 22

* Output loads
R_LOAD_I I_OUT 0 10k
R_LOAD_Q Q_OUT 0 10k

*======================================================================
* Analysis - 300us for baseband, 5ns step for RF
*======================================================================
.TRAN 0 300u 0 5n
.OPTIONS TIMEINT DELMAX=5n

.PRINT TRAN
+ V(PRI_P) V(SEC_A)
+ V(X_QSD:SAMP0) V(X_QSD:SAMP1) V(X_QSD:SAMP2) V(X_QSD:SAMP3)
+ V(I_OUT) V(Q_OUT)

.END
