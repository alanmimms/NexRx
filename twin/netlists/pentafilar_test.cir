* Pentafilar Transformer Test
* Test the 200Ω to 3×50Ω transformer in isolation

.INCLUDE 'components.lib'
.INCLUDE 'pentafilar.lib'

* 14 MHz source at 200 ohm impedance
V_SRC SRC 0 SIN(0 0.1 14MEG)
R_SRC SRC PRI_P 200

* Pentafilar transformer (PRI_P to PRI_N with PRI_N grounded)
X_PENTA PRI_P PRI_N SEC_A SEC_B SEC_C 0 XFMR_PENTAFILAR
R_PRI_TERM PRI_N 0 0.001

* 50 ohm loads on each secondary
R_LOAD_A SEC_A 0 50
R_LOAD_B SEC_B 0 50
R_LOAD_C SEC_C 0 50

* 2us simulation
.TRAN 1n 2u

.PRINT TRAN V(PRI_P) V(SEC_A) V(SEC_B) V(SEC_C)

.END
